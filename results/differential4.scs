simulator lang=spectre
global 0 gnd! vdd!
parameters use_tran=0 rfeedback_val=1000 dc_offset=0 gain_n=-0.5 tempc={{tempc}} vdd={{vdd}} vcm={{vcm}} vbiasp0={{vbiasp0}} vbiasp1={{vbiasp1}} vbiasp2={{vbiasp2}} vbiasn1={{vbiasn1}} vbiasn2={{vbiasn2}} nA1={{nA1}} nA10={{nA10}} nA11={{nA11}} nA12={{nA12}} nA2={{nA2}} nA3={{nA3}} nA4={{nA4}} nA5={{nA5}} nA6={{nA6}} nA7={{nA7}} nA8={{nA8}} nA9={{nA9}} nB1={{nB1}} nB10={{nB10}} nB11={{nB11}} nB12={{nB12}} nB2={{nB2}} nB3={{nB3}} nB4={{nB4}} nB5={{nB5}} nB6={{nB6}} nB7={{nB7}} nB8={{nB8}} nB9={{nB9}} nC0={{nC0}} nR0={{nR0}}

{% if fet_num == 7 %}
include "/homes/natelgrw/Documents/titan_foundation_model/lstp/7nfet.pm"
include "/homes/natelgrw/Documents/titan_foundation_model/lstp/7pfet.pm"
{% elif fet_num == 10 %}
include "/homes/natelgrw/Documents/titan_foundation_model/lstp/10nfet.pm"
include "/homes/natelgrw/Documents/titan_foundation_model/lstp/10pfet.pm"
{% elif fet_num == 14 %}
include "/homes/natelgrw/Documents/titan_foundation_model/lstp/14nfet.pm"
include "/homes/natelgrw/Documents/titan_foundation_model/lstp/14pfet.pm"
{% elif fet_num == 16 %}
include "/homes/natelgrw/Documents/titan_foundation_model/lstp/16nfet.pm"
include "/homes/natelgrw/Documents/titan_foundation_model/lstp/16pfet.pm"
{% elif fet_num == 20 %}
include "/homes/natelgrw/Documents/titan_foundation_model/lstp/20nfet.pm"
include "/homes/natelgrw/Documents/titan_foundation_model/lstp/20pfet.pm"
{% endif %}

*---Core---
*---Generated Circuit 4---
MM0 Voutp net10 gnd! gnd! nfet l=nA1 nfin=nB1
MM1 Vinn Vbiasn0 net6 gnd! nfet l=nA2 nfin=nB2
MM2 Vbiasn0 Vbiasn0 Vbiasn1 gnd! nfet l=nA5 nfin=nB5
MM3 Vinn Voutn net13 gnd! nfet l=nA6 nfin=nB6
MM4 Voutp gnd! Vbiasn2 vdd! pfet l=nA7 nfin=nB7
MM5 net0 net12 Voutp vdd! pfet l=nA8 nfin=nB8
MM6 net10 net11 net0 vdd! pfet l=nA9 nfin=nB9
MM7 net11 Vbiasn0 Vinp vdd! pfet l=nA10 nfin=nB10
MM8 net10 net6 net2 vdd! pfet l=nA11 nfin=nB11
MM9 net7 vdd! vdd! vdd! pfet l=nA12 nfin=nB12
MM10 net11 net12 Vbiasn1 vdd! pfet l=nA3 nfin=nB3
MM11 net7 net2 net13 vdd! pfet l=nA4 nfin=nB4
R0 (net6 vdd!) resistor r=nR0
C0 (net2 Vbiasn0) capacitor c=nC0

*---Ground, VDD, VCM Declarations---
VS (gnd! 0) vsource dc=0 type=dc
V0 (vdd! gnd!) vsource dc=vdd type=dc
V1 (cm gnd!) vsource dc=vcm type=dc

*---Voltage Input---
V2 (in gnd!) vsource dc=dc_offset type=dc mag=1
E1 (Vinp_norm cm in gnd!) vcvs gain=0.5
E0 (Vinn_norm cm in gnd!) vcvs gain=gain_n

*---Transient Input---
Vstep (in_tran gnd!) vsource type=pulse val0=(0.1 * vdd) val1=(0.9 * vdd) delay=1n rise=50p fall=50p width=100n period=200n
E3 (Vinp_tran cm in_tran gnd!) vcvs gain=0.5
E2 (Vinn_tran cm in_tran gnd!) vcvs gain=-0.5

*--- Switchable Inputs to Core ---
Rin1 (Vinp Vinp_norm) resistor r=(1 / (1 - use_tran + 1p))
Rin2 (Vinp Vinp_tran) resistor r=(1 / (use_tran + 1p))

Rin3 (Vinn Vinn_norm) resistor r=(1 / (1 - use_tran + 1p))
Rin4 (Vinn Vinn_tran) resistor r=(1 / (use_tran + 1p))

Rfeedback_p (Vinn Voutp) resistor r=((use_tran * rfeedback_val) + ((1 - use_tran) * 1T))
Rfeedback_n (Vinp Voutn) resistor r=((use_tran * rfeedback_val) + ((1 - use_tran) * 1T))

Ctran_p (Voutp gnd!) capacitor c=(use_tran * 50f)
Ctran_n (Voutn gnd!) capacitor c=(use_tran * 50f)

*---Bias Voltages---
VP (Vbiasp0 gnd!) vsource dc=vbiasp0 type=dc
VP1 (Vbiasp1 gnd!) vsource dc=vbiasp1 type=dc
VP2 (Vbiasp2 gnd!) vsource dc=vbiasp2 type=dc
VN1 (Vbiasn1 gnd!) vsource dc=vbiasn1 type=dc
VN2 (Vbiasn2 gnd!) vsource dc=vbiasn2 type=dc

simulatorOptions options psfversion="1.4.0" reltol=1e-3 vabstol=1e-6 \
    iabstol=1e-12 temp=tempc tnom=27 scalem=1.0 scale=1.0 gmin=1e-12 rforce=1 \
    maxnotes=5 maxwarns=5 digits=5 cols=80 pivrel=1e-3 \
    sensfile="../psf/sens.output" checklimitdest=psf

*---Noise Simulation---
noise (Voutp 0) noise start=1M stop=500M dec=20 iprobe=V2 annotate=status

*---AC Sweep---
acswp sweep param=gain_n start=-0.5 stop=0.5 step=1 {
    ac ac start=1 stop=100G dec=10 annotate=status
}

*---DC Sweep---
dcswp sweep param=dc_offset start=-0.5 stop=0.5 step=0.001 {
    dcOp dc write="spectre.dc" maxiters=150 maxsteps=10000 annotate=status
}

*---Transient Sweep---
transwp sweep param=use_tran values=[1] {
    mytran tran stop=200n step=5p annotate=status
}

dcOpInfo info what=oppoint where=rawfile
modelParameter info what=models where=rawfile
element info what=inst where=rawfile
outputParameter info what=output where=rawfile
designParamVals info what=parameters where=rawfile
primitives info what=primitives where=rawfile
subckts info what=subckts where=rawfile

saveOptions options save=allpub rawfmt=psfbin
