simulator lang=spectre
global 0 gnd! vdd!
parameters fet_num={{fet_num}} use_tran=0 rfeedback_val=1000 dc_offset=0 gain_n=-0.5 tempc={{tempc}} vdd={{vdd}} vcm={{vcm}} nA0={{nA0}} nA1={{nA1}} nA10={{nA10}} nA11={{nA11}} nA12={{nA12}} nA13={{nA13}} nA14={{nA14}} nA2={{nA2}} nA3={{nA3}} nA4={{nA4}} nA5={{nA5}} nA6={{nA6}} nA7={{nA7}} nA8={{nA8}} nA9={{nA9}} nB0={{nB0}} nB1={{nB1}} nB10={{nB10}} nB11={{nB11}} nB12={{nB12}} nB13={{nB13}} nB14={{nB14}} nB2={{nB2}} nB3={{nB3}} nB4={{nB4}} nB5={{nB5}} nB6={{nB6}} nB7={{nB7}} nB8={{nB8}} nB9={{nB9}} nC0={{nC0}} nR0={{nR0}} nR1={{nR1}} vbiasn0={{vbiasn0}} vbiasn2={{vbiasn2}} vbiasp0={{vbiasp0}}

{% if fet_num == 7 %}
include "/homes/natelgrw/Documents/titan_foundation_model/lstp/7nfet.pm"
include "/homes/natelgrw/Documents/titan_foundation_model/lstp/7pfet.pm"
{% elif fet_num == 10 %}
include "/homes/natelgrw/Documents/titan_foundation_model/lstp/10nfet.pm"
include "/homes/natelgrw/Documents/titan_foundation_model/lstp/10pfet.pm"
{% elif fet_num == 14 %}
include "/homes/natelgrw/Documents/titan_foundation_model/lstp/14nfet.pm"
include "/homes/natelgrw/Documents/titan_foundation_model/lstp/14pfet.pm"
{% elif fet_num == 16 %}
include "/homes/natelgrw/Documents/titan_foundation_model/lstp/16nfet.pm"
include "/homes/natelgrw/Documents/titan_foundation_model/lstp/16pfet.pm"
{% elif fet_num == 20 %}
include "/homes/natelgrw/Documents/titan_foundation_model/lstp/20nfet.pm"
include "/homes/natelgrw/Documents/titan_foundation_model/lstp/20pfet.pm"
{% endif %}

*---Core---
subckt Subckt_0 Vbiasn0 Vbiasn2 Vbiasp0 Vinn Vinp Voutp
*.PININFO Vbiasn0:I Vbiasn2:I Vbiasp0:I Vinn:I Vinp:I Voutp:O
MM0 vdd! Vbiasn0 net3 gnd! nfet l=nA0 nfin=nB0
MM1 net1 Vbiasn2 net2 gnd! nfet l=nA1 nfin=nB1
MM2 Voutp Vinp net0 gnd! nfet l=nA2 nfin=nB2
MM3 net0 Vinp Voutp gnd! nfet l=nA3 nfin=nB3
MM4 vdd! Vinp net0 vdd! pfet l=nA4 nfin=nB4
MM5 net1 Vbiasp0 vdd! vdd! pfet l=nA5 nfin=nB5
MM6 Voutp Vinp net2 vdd! pfet l=nA6 nfin=nB6
MM7 net3 Vinn gnd! vdd! pfet l=nA7 nfin=nB7
ends Subckt_0

subckt Subckt_1 Vbiasp0
*.PININFO Vbiasp0:O
MM8 net3 net3 vdd! gnd! nfet l=nA9 nfin=nB9
MM9 vdd! vdd! net3 gnd! nfet l=nA10 nfin=nB10
MM10 Vbiasp0 net0 gnd! vdd! pfet l=nA8 nfin=nB8
R0 (net3 net0) resistor r=nR0
ends Subckt_1

subckt Subckt_2 Vbiasn2
*.PININFO Vbiasn2:O
MM11 vdd! vdd! net3 gnd! nfet l=nA11 nfin=nB11
MM12 Vbiasn2 net3 net0 gnd! nfet l=nA12 nfin=nB12
MM13 net1 net0 net3 vdd! pfet l=nA13 nfin=nB13
MM14 net1 net1 net2 vdd! pfet l=nA14 nfin=nB14
R1 (net3 Vbiasn2) resistor r=nR1
C0 (net3 net2) capacitor c=nC0
ends Subckt_2

*---Bias Sources---
V_Vbiasn0 (Vbiasn0 gnd!) vsource dc=vbiasn0 type=dc
V_Vbiasn2 (Vbiasn2 gnd!) vsource dc=vbiasn2 type=dc
V_Vbiasp0 (Vbiasp0 gnd!) vsource dc=vbiasp0 type=dc

*---Instantiations---
xSubckt_0 Vbiasn0 Vbiasn2 Vbiasp0 Vinn Vinp Voutp Subckt_0
xSubckt_1 Vbiasp0 Subckt_1
xSubckt_2 Vbiasn2 Subckt_2

*---Ground, VDD, VCM Declarations---
VS (gnd! 0) vsource dc=0 type=dc
V0 (vdd! gnd!) vsource dc=vdd type=dc
V1 (cm gnd!) vsource dc=vcm type=dc

*---Voltage Input---
V2 (in gnd!) vsource dc=dc_offset type=dc mag=1
E1 (Vinp_norm cm in gnd!) vcvs gain=0.5
E0 (Vinn_norm cm in gnd!) vcvs gain=gain_n

*---Transient Input---
Vstep (in_tran gnd!) vsource type=pulse val0=(0.1 * vdd) val1=(0.9 * vdd) delay=1n rise=50p fall=50p width=100n period=200n
E3 (Vinp_tran cm in_tran gnd!) vcvs gain=0.5
E2 (Vinn_tran cm in_tran gnd!) vcvs gain=-0.5

*--- Switchable Inputs to Core ---
Rin1 (Vinp Vinp_norm) resistor r=(1 / (1 - use_tran + 1p))
Rin2 (Vinp Vinp_tran) resistor r=(1 / (use_tran + 1p))

Rin3 (Vinn Vinn_norm) resistor r=(1 / (1 - use_tran + 1p))
Rin4 (Vinn Vinn_tran) resistor r=(1 / (use_tran + 1p))

Rfeedback_p (Vinn Voutp) resistor r=((use_tran * rfeedback_val) + ((1 - use_tran) * 1T))

Ctran_p (Voutp gnd!) capacitor c=(use_tran * 50f)

simulatorOptions options rawfmt=psfbin psfversion="1.4.0" reltol=1e-3 vabstol=1e-6 \
    iabstol=1e-12 temp=tempc tnom=27 scalem=1.0 scale=1.0 gmin=1e-12 rforce=1 \
    maxnotes=5 maxwarns=5 digits=5 cols=80 pivrel=1e-3 \
    sensfile="../psf/sens.output" checklimitdest=psf

*---Noise Simulation---
noise (Voutp 0) noise start=1M stop=500M dec=20 iprobe=V2 annotate=status

*---AC Sweep---
acswp sweep param=gain_n start=-0.5 stop=0.5 step=1 {
    ac ac start=1 stop=100G dec=10 annotate=status
}

*---DC Sweep---
dcswp sweep param=dc_offset start=-0.5 stop=0.5 step=0.001 {
    dcOp dc write="spectre.dc" maxiters=150 maxsteps=10000 annotate=status
}

*---Transient Sweep---
transwp sweep param=use_tran values=[1] {
    mytran tran stop=200n step=5p annotate=status
}

dcOpInfo info what=oppoint where=rawfile
modelParameter info what=models where=rawfile
element info what=inst where=rawfile
outputParameter info what=output where=rawfile
designParamVals info what=parameters where=rawfile
primitives info what=primitives where=rawfile
subckts info what=subckts where=rawfile

saveOptions options save=allpub rawfmt=psfbin
