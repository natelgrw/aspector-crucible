simulator lang=spectre
global 0 gnd! vdd!
parameters use_tran=0 use_sine=0 dc_offset=0 mode_unity=0 run_gatekeeper={{run_gatekeeper}} run_full_char={{run_full_char}} fet_num={{fet_num}} vdd={{vdd}} vcm={{vcm}} tempc={{tempc}} rfeedback_val={{rfeedback_val}} rsrc_val={{rsrc_val}} cload_val={{cload_val}} vbiasn0={{vbiasn0}} vbiasp0={{vbiasp0}} nA1={{nA1}} nA2={{nA2}} nA3={{nA3}} nA6={{nA6}} nA8={{nA8}} nB1={{nB1}} nB4={{nB4}} nB7={{nB7}} nB8={{nB8}} nB9={{nB9}}

{% if fet_num == 7 %}
include "{{lstp_path}}/7nfet.pm"
include "{{lstp_path}}/7pfet.pm"
{% elif fet_num == 10 %}
include "{{lstp_path}}/10nfet.pm"
include "{{lstp_path}}/10pfet.pm"
{% elif fet_num == 14 %}
include "{{lstp_path}}/14nfet.pm"
include "{{lstp_path}}/14pfet.pm"
{% elif fet_num == 16 %}
include "{{lstp_path}}/16nfet.pm"
include "{{lstp_path}}/16pfet.pm"
{% elif fet_num == 20 %}
include "{{lstp_path}}/20nfet.pm"
include "{{lstp_path}}/20pfet.pm"
{% endif %}

*--- TOPOLOGY ---*

* Generated By ASPECTOR Crucible
* Derivative Netlist: single_ended_ota_nmos.scs
* Master Seed: 42
* Task Seed: 42
* Error Vector: 11100010_11100100
* Date: Sun Feb 15 04:43:17 EST 2026

*--- single_ended_ota_nmos_11100010_11100100_0 Vbiasn0 Vbiasp0 Vinn Vinp Voutp ---*
*.PININFO Vbiasn0:I Vbiasp0:I Vinn:I Vinp:I Voutp:O
MM0 gnd! gnd! gnd! net1 pfet l=nA8 nfin=nB7
MM1 vdd! vdd! vdd! net4 pfet l=nA1 nfin=nB1
MM2 vdd! vdd! vdd! net2 nfet l=nA2 nfin=nB9
MM3 vdd! gnd! vdd! net3 nfet l=nA3 nfin=nB8
MM4 gnd! Vbiasn0 gnd! gnd! nfet l=nA6 nfin=nB4

*--- TESTBENCH ---*

*--- Ground, VDD, & VCM ---*
VS (gnd! 0) vsource dc=0 type=dc
V0 (vdd! gnd!) vsource dc=vdd ac=1 type=dc
V1 (cm gnd!) vsource dc=vcm ac = 1 type=dc

*--- Signal Generation ---*
V2 (in_dc gnd!) vsource dc=dc_offset type=dc mag=1

Vstep (in_step gnd!) vsource type=pulse val0=(0.2 * vdd) val1=(0.8 * vdd) delay=5n rise=50p fall=50p width=100n period=200n
Vsine (in_sine gnd!) vsource type=sine ampl=(0.3 * vdd) freq=100M

Rsw_sine (in_tran in_sine) resistor r=(use_sine * 1m + (1 - use_sine) * 100G)
Rsw_step (in_tran in_step) resistor r=((1 - use_sine) * 1m + use_sine * 100G)

E_pos_dc (Vinp_dc_pre cm in_dc gnd!) vcvs gain=0.5
E_neg_dc (Vinn_dc_pre cm in_dc gnd!) vcvs gain=-0.5
E_pos_tr (Vinp_tr_pre cm in_tran gnd!) vcvs gain=0.5
E_neg_tr (Vinn_tr_pre cm in_tran gnd!) vcvs gain=-0.5

Rsrc_dc_p (Vinp_dc_pre Vinp_dc) resistor r=rsrc_val
Rsrc_dc_n (Vinn_dc_pre Vinn_dc) resistor r=rsrc_val
Rsrc_tr_p (Vinp_tr_pre Vinp_tr) resistor r=rsrc_val
Rsrc_tr_n (Vinn_tr_pre Vinn_tr) resistor r=rsrc_val

Rin_dc_p (Vinp Vinp_dc) resistor r=1m
Rin_tr_p (Vinp Vinp_tr) resistor r=1m
Rin_dc_n (Vinn Vinn_dc) resistor r=100G
Rin_tr_n (Vinn Vinn_tr) resistor r=100G

Rshunt_p (Vinp 0) resistor r=10G
Rshunt_n (Vinn 0) resistor r=10G
R_cm_fix_p (Voutp cm) resistor r=100M

*--- Mode Switching ---*
Vprobe (Voutp Vfb_node) vsource dc=0 type=dc
R_unity (Vinn Vfb_node) resistor r=(mode_unity * 1m + (1 - mode_unity) * 10G)

*--- Feedback & Load ---*
Rfeedback (Vinn Vfb_node) resistor r=((1 - mode_unity) * rfeedback_val + mode_unity * 10G)
Cload (Voutp gnd!) capacitor c=cload_val

*--- Bias Values ---*
VP0 (Vbiasp0 gnd!) vsource dc=vbiasp0 type=dc
VN0 (Vbiasn0 gnd!) vsource dc=vbiasn0 type=dc

*--- Simulator Options ---*
simulatorOptions options rawfmt=psfbin psfversion="1.4.0" reltol=1e-3 vabstol=1e-6     iabstol=1e-12 temp=tempc tnom=27 scalem=1.0 scale=1.0 gmin=1e-9 rforce=1     maxnotes=5 maxwarns=5 digits=5 cols=80 pivrel=1e-3     sensfile="../psf/sens.output" checklimitdest=psf

*--- SIMULATION TIER 1: The Gatekeeper ---
{% if run_gatekeeper %}
* Unity Gain Configuration (Open Loop)
a_unity alter param=mode_unity value=1
dcOp_sim dc
stb_ol stb probe=Vprobe start=1 stop=100G dec=10

* Closed Loop Configuration
a_closed alter param=mode_unity value=0
stb_cl stb probe=Vprobe start=1 stop=100G dec=10
{% endif %}

*--- SIMULATION TIER 2: Full Characterization ---
{% if run_full_char %}
xf_sim (Voutp 0) xf start=1 stop=100G dec=10
dc_sw dc
dc_swing dc param=dc_offset start=-0.1 stop=0.1 step=0.001
noise (Voutp 0) noise start=1 stop=100G dec=20 iprobe=V2 annotate=status

* THD Setup
a_thd_1 alter param=use_tran value=1
a_thd_2 alter param=use_sine value=1
thd_sim tran stop=100n step=2p fourier=yes fund=100M nodes=[Voutp]

* SLEW Setup
a_slew_1 alter param=use_sine value=0
slew_sim tran stop=200n step=5p
{% endif %}

*--- Data Export ---*
dcOpInfo info what=oppoint where=rawfile
modelParameter info what=models where=rawfile
element info what=inst where=rawfile
outputParameter info what=output where=rawfile
designParamVals info what=parameters where=rawfile
primitives info what=primitives where=rawfile
subckts info what=subckts where=rawfile
save V0:p Voutp Vinp Vinn MM0:gm MM0:vgs MM0:vds MM0:ids MM0:region MM1:gm MM1:vgs MM1:vds MM1:ids MM1:region MM2:gm MM2:vgs MM2:vds MM2:ids MM2:region MM3:gm MM3:vgs MM3:vds MM3:ids MM3:region MM4:gm MM4:vgs MM4:vds MM4:ids MM4:region
saveOptions options save=allpub rawfmt=psfbin
