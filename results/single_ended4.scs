simulator lang=spectre
global 0 gnd! vdd!
parameters fet_num={{fet_num}} use_tran=0 rfeedback_val=1000 dc_offset=0 gain_n=-0.5 tempc={{tempc}} vdd={{vdd}} vcm={{vcm}} ibias0={{ibias0}} nA1={{nA1}} nA2={{nA2}} nA3={{nA3}} nA4={{nA4}} nA5={{nA5}} nA6={{nA6}} nA7={{nA7}} nA8={{nA8}} nB1={{nB1}} nB2={{nB2}} nB3={{nB3}} nB4={{nB4}} nB5={{nB5}} nB6={{nB6}} nB7={{nB7}} nB8={{nB8}} nC0={{nC0}} nR0={{nR0}} vbiasn0={{vbiasn0}} vbiasp0={{vbiasp0}} vinn={{vinn}} vinp={{vinp}} voutp={{voutp}}

{% if fet_num == 7 %}
include "/homes/natelgrw/Documents/titan_foundation_model/lstp/7nfet.pm"
include "/homes/natelgrw/Documents/titan_foundation_model/lstp/7pfet.pm"
{% elif fet_num == 10 %}
include "/homes/natelgrw/Documents/titan_foundation_model/lstp/10nfet.pm"
include "/homes/natelgrw/Documents/titan_foundation_model/lstp/10pfet.pm"
{% elif fet_num == 14 %}
include "/homes/natelgrw/Documents/titan_foundation_model/lstp/14nfet.pm"
include "/homes/natelgrw/Documents/titan_foundation_model/lstp/14pfet.pm"
{% elif fet_num == 16 %}
include "/homes/natelgrw/Documents/titan_foundation_model/lstp/16nfet.pm"
include "/homes/natelgrw/Documents/titan_foundation_model/lstp/16pfet.pm"
{% elif fet_num == 20 %}
include "/homes/natelgrw/Documents/titan_foundation_model/lstp/20nfet.pm"
include "/homes/natelgrw/Documents/titan_foundation_model/lstp/20pfet.pm"
{% endif %}

*---Core---
subckt Subckt_0 Ibias0 Vbiasn0 Vbiasp0 Vinn Vinp Voutp
*.PININFO Ibias0:I Vbiasn0:I Vbiasp0:I Vinn:I Vinp:I Voutp:O
MM0 Voutp net1 Vbiasp0 gnd! nfet l=nA1 nfin=nB1
MM1 Vbiasn0 net1 Vinn gnd! nfet l=nA2 nfin=nB2
MM2 Ibias0 vdd! Vinp vdd! pfet l=nA3 nfin=nB3
MM3 Vbiasn0 gnd! Voutp vdd! pfet l=nA4 nfin=nB4
R0 (vdd! Voutp) resistor r=nR0
C0 (Voutp Vinn) capacitor c=nC0
ends Subckt_0

subckt Subckt_1 Vbiasn0 Vbiasp0
*.PININFO Vbiasn0:I Vbiasp0:I
MM0 Vbiasn0 Vbiasp0 net2 gnd! nfet l=nA5 nfin=nB5
MM1 net0 net2 net2 gnd! nfet l=nA6 nfin=nB6
MM2 net2 net0 net0 vdd! pfet l=nA7 nfin=nB7
MM3 net0 net0 vdd! vdd! pfet l=nA8 nfin=nB8
R0 (Vbiasp0 Vbiasn0) resistor r=nR0
C0 (net2 Vbiasp0) capacitor c=nC0
ends Subckt_1

*---Bias Sources---
I_Ibias0 (Ibias0 gnd!) isource dc=ibias0 type=dc
V_Vbiasn0 (Vbiasn0 gnd!) vsource dc=vbiasn0 type=dc
V_Vbiasp0 (Vbiasp0 gnd!) vsource dc=vbiasp0 type=dc

*---Instantiations---
xSubckt_0 Ibias0 Vbiasn0 Vbiasp0 Vinn Vinp Voutp Subckt_0
xSubckt_1 Vbiasn0 Vbiasp0 Subckt_1

*---Ground, VDD, VCM Declarations---
VS (gnd! 0) vsource dc=0 type=dc
V0 (vdd! gnd!) vsource dc=vdd type=dc
V1 (cm gnd!) vsource dc=vcm type=dc

*---Voltage Input---
V2 (in gnd!) vsource dc=dc_offset type=dc mag=1
E1 (Vinp_norm cm in gnd!) vcvs gain=0.5
E0 (Vinn_norm cm in gnd!) vcvs gain=gain_n

*---Transient Input---
Vstep (in_tran gnd!) vsource type=pulse val0=(0.1 * vdd) val1=(0.9 * vdd) delay=1n rise=50p fall=50p width=100n period=200n
E3 (Vinp_tran cm in_tran gnd!) vcvs gain=0.5
E2 (Vinn_tran cm in_tran gnd!) vcvs gain=-0.5

*--- Switchable Inputs to Core ---
Rin1 (Vinp Vinp_norm) resistor r=(1 / (1 - use_tran + 1p))
Rin2 (Vinp Vinp_tran) resistor r=(1 / (use_tran + 1p))

Rin3 (Vinn Vinn_norm) resistor r=(1 / (1 - use_tran + 1p))
Rin4 (Vinn Vinn_tran) resistor r=(1 / (use_tran + 1p))

Rfeedback_p (Vinn Voutp) resistor r=((use_tran * rfeedback_val) + ((1 - use_tran) * 1T))

Ctran_p (Voutp gnd!) capacitor c=(use_tran * 50f)

simulatorOptions options rawfmt=psfbin psfversion="1.4.0" reltol=1e-3 vabstol=1e-6 \
    iabstol=1e-12 temp=tempc tnom=27 scalem=1.0 scale=1.0 gmin=1e-12 rforce=1 \
    maxnotes=5 maxwarns=5 digits=5 cols=80 pivrel=1e-3 \
    sensfile="../psf/sens.output" checklimitdest=psf

*---Noise Simulation---
noise (Voutp 0) noise start=1M stop=500M dec=20 iprobe=V2 annotate=status

*---AC Sweep---
acswp sweep param=gain_n start=-0.5 stop=0.5 step=1 {
    ac ac start=1 stop=100G dec=10 annotate=status
}

*---DC Sweep---
dcswp sweep param=dc_offset start=-0.5 stop=0.5 step=0.001 {
    dcOp dc write="spectre.dc" maxiters=150 maxsteps=10000 annotate=status
}

*---Transient Sweep---
transwp sweep param=use_tran values=[1] {
    mytran tran stop=200n step=5p annotate=status
}

dcOpInfo info what=oppoint where=rawfile
modelParameter info what=models where=rawfile
element info what=inst where=rawfile
outputParameter info what=output where=rawfile
designParamVals info what=parameters where=rawfile
primitives info what=primitives where=rawfile
subckts info what=subckts where=rawfile

saveOptions options save=allpub rawfmt=psfbin
